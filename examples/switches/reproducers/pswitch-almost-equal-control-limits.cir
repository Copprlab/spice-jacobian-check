Independent pswitch-almost-equal-control-limits
VDR IN 0 DC .1
VCTRL DRIVE 0 DC 2.4999999999999999e-13
RC DRIVE CTRL 0
A1 %gd CTRL 0 %gd IN OUT MODE
.model MODE pswitch(r_on=100 r_off=10000 cntl_on=4.9999999999999999e-13 cntl_off=0 log=true r_cntl_in=1000000000000)
RL OUT 0 1k
.end
